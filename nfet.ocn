simulator( 'spectre )
design( "gmid180" "nfet" "schematic" ) ;EDIT TO YOUR DESIGN LIBRARY AND CELL NAME
resultsDir( /Users/Grad/sambady/gpdk180/Curves/spectre/schematic" ) ;EDIT TO YOUR RESULTS PATH

;EDIT TO YOUR ENVIRONMENT PATH TO PDK MODELS
modelFile(
    '("/ECEnet/Apps1/linux/cad12/tools/PDKs/gpdk180_v3.3/models/spectre/gpdk.scs" "stat")
)

;Convert constant variables to waves. Final wave will be length of refwave
procedure(
	vartowave(var refwave)
		varwave0 = ((refwave+1) * var) ;+1 to avoid any divide by zeros
		varwave1 = (varwave0 / (refwave+1))
		varwave1 ;return variable as a wave with length of refwave
)

;;;;;;;;;;;;;
;Procedure wrapper for simulation generated by ADE
;;;;;;;;;;;;;
procedure(
	simsweep( outputfile length_in vsb_in vds_in )
		analysis( 'dc ?saveOppoint t  ?param "vgs"  ?start "300m"  ?stop "1.8"  ?step "25m" )
		;analysis( 'dc ?saveOppoint t )
		desVar(	  "F" 5	)
		desVar(	  "L" length_in	)
		desVar(	  "vds" vds_in	)
		desVar(	  "vgs" 600m	)
		desVar(	  "vsb" vsb_in	)
		desVar(	  "W" 10u	)
		envOption(
			'analysisOrder  list("dc")
		)
		saveOpPoint( "/MN0" ?operatingPoints "ids vgs vds vbs vgd vth vdsat gm gds gmbs beff cjd cjs cgg cgd cgs cgb cdg cdd cds cdb csg csd css csb cbg cbd cbs cbb ron id pwr gmoverid ueff vsb gmb vgt vdss self_gain rout vearly ft region" )
		temp( 27 )
		run()
		print("RUN")

		vgs = abs(OS("/MN0" "vgs"))
		vds = abs(OS("/MN0" "vds"))
		vsb = abs(OS("/MN0" "vsb"))
		gm = abs(OS("/MN0" "gm"))
		gmb = abs(OS("/MN0" "gmb"))
		gds = abs(OS("/MN0" "gds"))
		ron = abs(OS("/MN0" "ron"))
		vdsat = abs(OS("/MN0" "vdsat"))
		vth = abs(OS("/MN0" "vth"))
		vearly = abs(OS("/MN0" "vearly"))
		id = abs(OS("/MN0" "id"))
		cgg = abs(OS("/MN0" "cgg"))
		cgs = abs(OS("/MN0" "cgs"))
		cgb = abs(OS("/MN0" "cgb"))
		cgd = abs(OS("/MN0" "cgd"))
		cds = abs(OS("/MN0" "cds"))
		beff = abs(OS("/MN0" "beff"))

		length_wave = vartowave( VAR("L") vds ) ;convert length to wave so it can be a filterable column in the data
		width_wave = vartowave( VAR("W") vds )

		ocnPrint( ?output outputfile ?numberNotation 'engineering ?numSpaces 4 length_wave width_wave vgs vds vsb gm gmb gds ron vdsat vth vearly id cgg cgs cgb cgd cds beff) ;output DC sweep to temp file
)

resultscsv = outfile( "./nfet_gmid.csv" "w") ;Create empty CSV
close(resultscsv)

;;;;;;;;;;;;;
;Create lengths, vgs, vsb, and vds to iterate through. Modify this however you want for whatever you need
;;;;;;;;;;;;;

len_list = list( 180e-9 )
for( i 2 20
	next = 100e-9 * i
	len_list = cons( next len_list )
)
for( i 9 20
	next = 250e-9 * i
	len_list = cons( next len_list )
)
for( i 11 20
	next = 500e-9 * i
	len_list = cons( next len_list )
)

vsb_list = list( 0 500e-3 1 )

vds_list = list( 0 )
for( i 1 10
	next = 10e-3 * i
	vds_list = cons( next vds_list )
)
for( i 3 24
	next = 50e-3 * i
	vds_list = cons( next vds_list )
)
for( i 13 18
	next = 100e-3 * i
	vds_list = cons( next vds_list )
)

;;;;;;;;;;;;;
;Loops iterating through each variable, running sim, and saving to CSV. This is the meat of it
;;;;;;;;;;;;;

for( k 1 length(vsb_list)
	for( j 1 length(len_list)
		for( q 1 length(vds_list)
			tempout = outfile( "./adel_out.out" "w")
			simsweep(tempout nthelem(j len_list) nthelem(k vsb_list) nthelem(q vds_list)) ;simulation run and saved to temporary output file
			close(tempout)

			;system(sprintf(nil "sed -i '2 r ./nfet_gmid.csv' adel_out.out")) ;existing CSV inserted into output file below header
			system(sprintf(nil "sed -i '/^[[:space:]]*$/d' adel_out.out")) ;empty lines deleted
			;system(sprintf(nil "sed -i '1d' adel_out.out")) ;header deleted
			;system(sprintf(nil "rm -rf ./nfet_gmid.csv")) ;old CSV deleted
			;system(sprintf(nil "mv ./adel_out.out ./nfet_gmid.csv")) ;new output file renamed as CSV
			system(sprintf(nil "sed -i -e '1d' adel_out.out"))
			system(sprintf(nil "cat adel_out.out >> nfet_gmid.csv"))
			;system(sprintf(nil "rm -rf ./adel_out.out"))
		)
	)
)
print("Job done")
;;;;;;;;;;;;;
