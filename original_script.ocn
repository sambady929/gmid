simulator( 'spectre )
design(	 "/tmp/nfet/spectre/schematic/netlist/netlist")
resultsDir( "/tmp/nfet/spectre/schematic" )
modelFile(
    '("/ECEnet/Apps1/linux/cad12/tools/PDKs/gpdk180_v3.3/models/spectre/gpdk.scs" "stat")
)
analysis('dc ?saveOppoint t  ?param "vgs"  ?start "0"
		?stop "1.8"  ?step "50m"  )
desVar(	  "L" 180n	)
desVar(	  "W" 10u	)
desVar(	  "vbs" 0	)
desVar(	  "vds" 400m	)
desVar(	  "vgs" 500m	)
envOption(
	'analysisOrder  list("dc")
)
saveOpPoint( "/NM0" ?operatingPoints "ids vgs vds vbs vgd vth vdsat gm gds gmbs cjd cjs cgg cgd cgs cgb cdg cdd cds cdb csg csd css csb cbg cbd cbs cbb ron id pwr gmoverid ueff vsb gmb vgt vdss self_gain rout vearly ft region" )
temp( 27 )
run()
gm = OS("/NM0" "gm")
Id = OS("/NM0" "ids")
gmId = (gm / Id)
Jd = (Id / VAR("W"))
cgg = OS("/NM0" "cgg")
ft = (gm / (2 * 3.141593 * cgg))
gds = OS("/NM0" "gds")
Avo = (gm / gds)
FoM = (Avo * ft)
ft_Jd = waveVsWave(?x Jd ?y ft)
plot( ft_Jd ?expr '( "ft_Jd" ) )
FoM_Jd = waveVsWave(?x Jd ?y FoM)
plot( FoM_Jd ?expr '( "FoM_Jd" ) )
gmId_Jd = waveVsWave(?x Jd ?y gmId)
plot( gmId_Jd ?expr '( "gmId_Jd" ) )
Avo_gmid = waveVsWave(?x gmId ?y Avo)
plot( Avo_gmid ?expr '( "Avo_gmid" ) )
