;;;;;;;;;;;;;
;Written and Directed by Shrid Ambady, 2024
;;;;;;;;;;;;;
;Not for personal, professional, or commercial use
;This script is copyrighted by the NFL for the private use of our audience.
;Any other use of this script or any pictures, descriptions, or accounts of the simulation without the NFL's consent is prohibited.
;;;;;;;;;;;;;

;;;;;;;;;;;;;
;Header for setup. Will be specific to your install and environment
;;;;;;;;;;;;;
simulator( 'spectre )
design(	 "/tmp/nfet/spectre/schematic/netlist/netlist")
resultsDir( "/tmp/nfet/spectre/schematic" )
modelFile(
    '("/ECEnet/Apps1/linux/cad12/tools/PDKs/gpdk180_v3.3/models/spectre/gpdk.scs" "stat")
)
;;;;;;;;;;;;;

;Convert constant variables to waves. Final wave will be length of refwave
procedure(
	vartowave(var refwave)
		varwave0 = ((refwave+1) * var) ;+1 to avoid any divide by zeros (and also removes pesky truncation errors if your refwave is made up of like 10e-18 numbers or something
		varwave1 = (varwave0 / (refwave+1))
		varwave1 ;return variable as a wave with length of refwave
)

;;;;;;;;;;;;;
;Procedure wrapper for simulation generated by ADE
;;;;;;;;;;;;;
procedure(
	simsweep(outputfile length_in vbs_in vds_in)
		analysis('dc ?saveOppoint t  ?param "vgs"  ?start "0"
				?stop "1.8"  ?step "10m"  )
		desVar(	  "L" length_in	) ;value replaced by procedure argument
		desVar(	  "W" 10u	)
		desVar(	  "vbs" vbs_in	)
		desVar(	  "vds" vds_in	)
		desVar(	  "vgs" 500m	)
		envOption(
			'analysisOrder  list("dc")
		)
		saveOpPoint( "/NM0" ?operatingPoints "ids vgs vds vbs vgd vth vdsat gm gds gmbs cjd cjs cgg cgd cgs cgb cdg cdd cds cdb csg csd css csb cbg cbd cbs cbb ron id pwr gmoverid ueff vsb gmb vgt vdss self_gain rout vearly ft region" )
		temp( 27 )
		run()

		vgs = OS("/NM0" "vgs")
		vds = OS("/NM0" "vds")
		vsb = OS("/NM0" "vsb")
		gm = OS("/NM0" "gm")
		Id = OS("/NM0" "ids")
		gmId = (gm / Id)
		Jd = (Id / VAR("W"))
		cgg = OS("/NM0" "cgg")
		ft = (gm / (2 * 3.141593 * cgg))
		gds = OS("/NM0" "gds")
		Avo = (gm / gds)
		FoM = (Avo * ft)

		length_wave = vartowave( VAR("L") vgs ) ;convert length to wave so it can be a filterable column in the data

		ocnPrint( ?output outputfile ?numberNotation 'engineering ?numSpaces 10 length_wave vds vsb gm Id gds cgg gmId Jd ft Avo FoM) ;output DC sweep to temp file
)
;;;;;;;;;;;;;

resultscsv = outfile( "./nfet_gmid.csv" "w") ;Create empty CSV
close(resultscsv)

;;;;;;;;;;;;;
;Create lengths, vsb, and vds to iterate through. Modify this however you want for whatever you need
;;;;;;;;;;;;;
len_list = list( 180e-9 )
for( i 2 10
	next = 100e-9 * i
	len_list = cons( next len_list )
)

vbs_list = list( 0 ) ;I don't particularly care about body effect right now, I generally neglect it in my designs

vds_list = nil
for( i 1 39
	next = 50e-3 * i
	vds_list = cons( next vds_list )
)

print(len_list)
print(vds_list)
;;;;;;;;;;;;;

;;;;;;;;;;;;;
;Loops iterating through each variable, running sim, and saving to CSV. This is the meat of it
;;;;;;;;;;;;;
foreach( vbs vbs_list
	foreach( len len_list
		foreach( vds vds_list
			tempout = outfile( "./adel_out.out" "w")
			simsweep(tempout len vbs vds) ;simulation run and saved to temporary output file
			close(tempout)

			system(sprintf(nil "sed -i '2 r ./nfet_gmid.csv' adel_out.out")) ;existing CSV inserted into output file below header
			system(sprintf(nil "sed -i '/^[[:space:]]*$/d' adel_out.out")) ;empty lines deleted
			system(sprintf(nil "sed -i '1d' adel_out.out")) ;header deleted
			system(sprintf(nil "rm -rf ./nfet_gmid.csv")) ;old CSV deleted
			system(sprintf(nil "mv ./adel_out.out ./nfet_gmid.csv")) ;new output file renamed as CSV
		)
	)
)
;;;;;;;;;;;;;
;;;;;;;;;;;;; Semicolons kinda look like chili peppers don't they?
;;;;;;;;;;;;; I'm getting a weird semantic satiation from them
